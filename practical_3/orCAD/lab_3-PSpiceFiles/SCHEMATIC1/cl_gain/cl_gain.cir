** Profile: "SCHEMATIC1-cl_gain"  [ C:\USERS\SHANE REYNOLDS\DOCUMENTS\ENG471_ANALOGDEVICES\lab_3\lab_3-PSpiceFiles\SCHEMATIC1\cl_gain.sim ]

** Creating circuit file "cl_gain.cir"
** WARNING: THIS AUTOMATICALLY GENERATED FILE MAY BE OVERWRITTEN BY SUBSEQUENT SIMULATIONS

*Libraries:
* Profile Libraries :
* Local Libraries :
* From [PSPICE NETLIST] section of C:\Users\Shane Reynolds\AppData\Roaming\SPB_Data\cdssetup\OrCAD_PSpice/16.6.0/PSpice.ini file:
.lib "nomd.lib"

*Analysis directives:
.AC DEC 10 10 100000000
.OPTIONS ADVCONV
.PROBE64 V(alias(*)) I(alias(*)) W(alias(*)) D(alias(*)) NOISE(alias(*))
.INC "..\SCHEMATIC1.net"

.END
